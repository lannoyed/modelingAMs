// disciplines.vams — project-wide discipline & connectrule declarations
// Target: Siemens Questa ADMS / Symphony. Include this in every compile.
`include "disciplines.vams"   // standard Accellera header (electrical, logic, ...)
`include "constants.vams"

// --- Signal-flow disciplines (no current loading) ---
discipline voltage
  potential Voltage;
enddiscipline

discipline current
  flow Current;
enddiscipline

// --- Connect rules: state these explicitly; Symphony auto-inserts CMs to match ---
connectrules e2l_l2e;
  connect e2l_module input electrical, output logic;   // driver = analog
  connect l2e_module input logic, output electrical;   // driver = digital
endconnectrules
