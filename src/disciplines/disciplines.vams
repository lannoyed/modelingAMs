// disciplines.vams — project-wide discipline declarations
// Target: Siemens Questa ADMS / Symphony. Include this in every compile.
`include "disciplines.vams"   // standard Accellera header (electrical, logic, ...)
`include "constants.vams"

// --- Signal-flow disciplines (no current loading) ---
discipline voltage
  potential Voltage;
enddiscipline

discipline current
  flow Current;
enddiscipline

// Digital<->electrical boundaries rely on Symphony's automatic connect
// modules (A2D/D2A/A2R/R2A); no project-specific connect module is declared.
