// sc_tripler_PARAM.vams — default parameter values for sc_tripler.
// Included directly inside sc_tripler's ANSI parameter port list #( ... ).
// No `from`/`exclude` clauses here: Symphony's ADMS front end rejects
// value-range clauses on parameters declared inside an ANSI-style parameter
// port list (confirmed a tool nonconformance against VAMS-2023 Annex A.2, not
// an LRM restriction -- see generic_switch.vams's header note). c1/c2 are
// range-guarded at runtime in sc_tripler.vams's analog initial block instead;
// ron_tier1/2/3, roff, trise, tfall are pure passthrough overrides into
// generic_switch, which guards them itself.
// Sub-modules (generic_switch) never include this file directly; they
// receive values solely through instantiation parameter overrides from
// sc_tripler.
    parameter real c1        = 100n,   // flying cap 1 [F]; must be > 0, else clamped (see analog initial guard)
    parameter real c2        = 100n,   // flying cap 2 [F]; must be > 0, else clamped
    parameter real ron_tier1 = 50m,    // Ron for tier-1 (<=Vin) switches [Ohm]; guarded by generic_switch
    parameter real ron_tier2 = 50m,    // Ron for tier-2 (<=2*Vin) switches [Ohm]; guarded by generic_switch
    parameter real ron_tier3 = 50m,    // Ron for tier-3 (<=3*Vin) switches [Ohm]; guarded by generic_switch
    parameter real roff      = 100M,   // shared off-state leakage resistance [Ohm]; guarded by generic_switch
    parameter real trise     = 1n,     // switch control turn-on edge [s]; guarded by generic_switch
    parameter real tfall     = 1n      // switch control turn-off edge [s]; guarded by generic_switch
