// generic_switch.vams — ideal analog switch, smooth on/off conductance blend.
//
// Why: every controlled switch (SC converter phase switch, mux element, sample
// gate, ...) needs the same behavior: interpolate directly to an on/off
// *conductance* target and let transition() own the commutation edge, so
// Newton never sees a hard branch. One reusable primitive replaces per-site
// copy-pasted conductance equations (composition over copy-paste). This
// module carries no notion of what circuit instantiates it or what voltage it
// blocks -- that bookkeeping (e.g. sc_tripler_top's ron_tier1/2/3 naming)
// belongs to the caller, not here (see "Dropped: tier" below).
//
// LRM/Symphony features: `ctrl` is a plain digital `wire`; Symphony's
// automatic D2A connect module supplies its resolved real value where the
// `ctrl === 1` comparison and transition() call need one, so no
// project-specific connect module is instantiated here. transition()'s first
// argument is the target conductance itself (gon or goff, chosen by `ctrl`),
// not the raw digital signal -- it re-evaluates every analog step and smooths
// the *value* jump between gon and goff over trise/tfall, so this module owns
// commutation smoothness for Newton.
//
// Dropped: tier. sc_switch (this module's predecessor) carried a `tier`
// integer purely for traceability against a converter's switch-stress table;
// it never fed the equations. A parameter that never reaches an `<+`
// contribution is dead weight on every instance -- the caller can express the
// same stress-tier intent through parameter naming (ron_tier1/2/3) or a
// comment at the instantiation site instead of a carried-but-unused port.
//
// Range guards: this is a sub-module (instantiated with per-instance
// overrides, e.g. by sc_tripler_top), so its ANSI header stays bare -- no
// `from`/`exclude` -- to keep those overrides binding reliably at Symphony
// elaboration (see pitfalls/parameters.md's `_top`-vs-sub-module convention).
// Ranges are checked at runtime instead, in a plain `initial` block kept
// separate from the module's one `analog` block (Symphony accepts exactly
// one `analog` block per module; ordinary `initial` blocks are unrestricted,
// so the guard lives there instead of nested inside the analog block via
// @(initial_step)): `$error` at t=0 on an out-of-range override halts the
// run with a clear diagnostic rather than silently substituting a default or
// letting a divide-by-zero/negative-time propagate into the analog
// equations.
//
// Limitations: no charge-injection, no dV/dt-dependent Ron, no body diode.
// Ideal-switch macromodel only; sufficient for exploring the SSL/FSL
// output-impedance corner of a converter, not for gate-drive or
// charge-injection studies.

`include "disciplines.vams"
`include "constants.vams"

module generic_switch #(
    parameter real ron   = 50e-3,  // on-resistance [Ohm]; must be > 0
    parameter real roff  = 100e6,  // off leakage resistance [Ohm]; must be > 0
    parameter real trise = 1e-9,   // control turn-on edge [s]; must be > 0
    parameter real tfall = 1e-9    // control turn-off edge [s]; must be > 0
) (
    inout p, n,
    input wire ctrl
);
  electrical p, n;

  localparam real gon  = 1.0 / ron;    // parameter-time constants: computed once, not per analog evaluation
  localparam real goff = 1.0 / roff;

  // Parameter guard: plain `initial`, not `analog` -- Symphony allows only
  // one `analog` block per module, so this stays out of it entirely rather
  // than nesting @(initial_step) inside the block below.
  initial begin
    if (ron <= 0.0)
      $error("generic_switch %m: ron=%g out of range (0:inf)", ron);
    if (roff <= 0.0)
      $error("generic_switch %m: roff=%g out of range (0:inf)", roff);
    if (trise <= 0.0)
      $error("generic_switch %m: trise=%g out of range (0:inf)", trise);
    if (tfall <= 0.0)
      $error("generic_switch %m: tfall=%g out of range (0:inf)", tfall);
  end

  analog begin
    // ctrl === 1 falls through to goff (off) on x/z, not just a clean 0 --
    // the safer failure mode when the digital side hasn't resolved yet.
    I(p, n) <+ V(p, n) * transition((ctrl === 1) ? gon : goff, 0, trise, tfall);
  end
endmodule
