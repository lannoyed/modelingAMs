// sc_switch.vams — ideal analog switch for switched-capacitor charge-transfer paths.
//
// Why: every phase switch in a SC converter needs the same behavior (smooth
// on/off conductance blend, no hard branch) but a different on-resistance
// depending on which voltage tier it operates at. One reusable module,
// instantiated per switch with a tier-appropriate `ron`, replaces eight
// hand-copied conductance equations (composition over copy-paste).
//
// LRM/Symphony features: `ctrl` is a plain digital `wire`; Symphony's
// automatic D2A connect module supplies its real value where `transition()`
// needs one, so no project-specific connect module is instantiated here.
// `transition()` supplies the finite turn-on/off edge directly on the digital
// control signal -- the only place in this module that owns commutation
// smoothness for Newton.
//
// Limitations: no charge-injection, no dV/dt-dependent Ron, no body diode.
// Ideal-switch macromodel only; sufficient for exploring the SSL/FSL output-
// impedance corner of a converter, not for gate-drive or charge-injection studies.

`include "disciplines.vams"
`include "constants.vams"

module sc_switch #(
    parameter real    ron   = 50m  from (0:inf),   // on-resistance [Ohm] -- sets this switch's FSL contribution
    parameter real    roff  = 100M from (0:inf),   // off leakage resistance [Ohm]; finite so 1/roff never divides by zero
    parameter integer tier  = 1    from [1:3],     // documents V_DS stress tier (1=Vin, 2=2*Vin, 3=3*Vin); not used
                                                    // in the equations below -- carried for traceability against the
                                                    // converter's switch-stress table when picking ron per instance.
    parameter real    trise = 1n   from (0:inf),   // control turn-on edge [s]
    parameter real    tfall = 1n   from (0:inf)    // control turn-off edge [s]
) (
    inout p, n,
    input wire ctrl
);
  electrical p, n;

  localparam real gon  = 1.0 / ron;    // parameter-time constants: computed once, not per analog evaluation
  localparam real goff = 1.0 / roff;

  analog begin
    I(p, n) <+ V(p, n) * (goff + (gon - goff) * transition(ctrl, 0, trise, tfall));
  end
endmodule
